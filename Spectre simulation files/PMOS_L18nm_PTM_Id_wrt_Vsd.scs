// Design: Test_FinFET/PMOS_L18nm_PTM_Id_wrt_Vsd
simulator lang=spectre
global 0
parameters temperature=27 Vsd=0.4 Vsg=0.45
include "/home/avulpe_research/Desktop/FinFET/models.unknown" section=ptm14lstp

// Test_FinFET/PMOS_L18nm_PTM_Id_wrt_Vsd/schematic
V8 (Vsd net3) vsource dc=Vsg type=dc
V3 (Vsd 0) vsource dc=Vsd type=dc
M0 (0 net3 Vsd Vsd) pfet
simulatorOptions options temp=27 redefinedparams=warning
dcOp dc
dc dc param=Vsd start=0 stop=0.8
save Vsd M0:s
// saveOptions options save=all pwr=all currents=all saveahdlvars=all
