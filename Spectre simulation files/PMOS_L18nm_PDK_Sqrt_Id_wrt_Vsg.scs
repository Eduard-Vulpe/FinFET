// Design: Test_FinFET/PMOS_L18nm_PDK_Sqrt_Id_wrt_Vsg
simulator lang=spectre
global 0
parameters temperature=27 Vsd=0.45 Vsg=0.4
include "/opt/designKits/research/04_FinFET_Cadence/cds_ff_mpt_v_1.1/cds_ff_mpt/../models/spectre/cds_ff_mpt.scs" section=tt

// Test_FinFET/PMOS_L18nm_PDK_Sqrt_Id_wrt_Vsg/schematic
V8 (Vsd net3) vsource dc=Vsg type=dc
V3 (Vsd 0) vsource dc=Vsd type=dc
PM0 (0 net3 Vsd Vsd) cds_ff_mpt_p1hvt l=18.0n nfin=1 nf=1 m=1 ngcon=1
simulatorOptions options temp=27
dcOp dc
dc dc param=Vsg start=0 stop=0.8
save Vsg PM0:s
// saveOptions options save=all pwr=all currents=all saveahdlvars=all
