// Design: Test_FinFET/NMOS_L18nm_PDK_Sqrt_Id_wrt_Vgs
simulator lang=spectre
global 0
parameters temperature=27 Vds=0.45 Vgs=0.4
include "/opt/designKits/research/04_FinFET_Cadence/cds_ff_mpt_v_1.1/cds_ff_mpt/../models/spectre/cds_ff_mpt.scs" section=tt

// Test_FinFET/NMOS_L18nm_PDK_Sqrt_Id_wrt_Vgs/schematic
V1 (Vds 0) vsource dc=Vds type=dc
V0 (Vgs 0) vsource dc=Vgs type=dc
NM1 (Vds Vgs 0 0) cds_ff_mpt_n1hvt l=18.0n nfin=1 nf=1 m=1 ngcon=1
simulatorOptions options temp=27
dcOp dc
dc dc param=Vgs start=0 stop=0.8
save Vgs NM1:d
// saveOptions options save=all pwr=all currents=all saveahdlvars=all
