// Design: Test_FinFET/NMOS_L18nm_PTM__Sqrt_Id_wrt_Vgs
simulator lang=spectre
global 0
parameters temperature=27 Vds=0.45 Vgs=0.4
include "/home/avulpe_research/Desktop/FinFET/models.unknown" section=ptm14lstp

// Test_FinFET/NMOS_L18nm_PTM__Sqrt_Id_wrt_Vgs/schematic
V1 (Vds 0) vsource dc=Vds type=dc
V0 (Vgs 0) vsource dc=Vgs type=dc
M0 (Vds Vgs 0 0) nfet
simulatorOptions options temp=27 redefinedparams=warning
dc dc param=Vgs start=0 stop=0.8
save Vgs M0:d
//saveOptions options save=allpub
