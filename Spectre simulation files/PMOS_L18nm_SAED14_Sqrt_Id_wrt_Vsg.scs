// Design: Test_FinFET/PMOS_L18nm_SAED14_Sqrt_Id_wrt_Vsg
simulator lang=spectre
global 0
parameters temperature=27 Vsd=0.45 Vsg=0.4
include "/home/avulpe_research/Desktop/SAED14_PDK/hspice/saed14nm.lib" section=TT

// Test_FinFET/PMOS_L18nm_SAED14_Sqrt_Id_wrt_Vsg/schematic
V8 (Vsd net3) vsource dc=Vsg type=dc
V3 (Vsd 0) vsource dc=Vsd type=dc
M0 (0 net3 Vsd Vsd) p08_hvt
simulatorOptions options temp=27 redefinedparams=warning
dcOp dc
dc dc param=Vsg start=0 stop=0.8
save Vsg M0:s
// saveOptions options save=all pwr=all currents=all saveahdlvars=all
