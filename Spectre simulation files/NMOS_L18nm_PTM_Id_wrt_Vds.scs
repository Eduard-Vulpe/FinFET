// Design: Test_FinFET/NMOS_L18nm_PTM_Id_wrt_Vds
simulator lang=spectre
global 0
parameters temperature=27 Vds=0.4 Vgs=0.45
include "/home/avulpe_research/Desktop/FinFET/models.unknown" section=ptm14lstp

// Test_FinFET/NMOS_L18nm_PTM_Id_wrt_Vds/schematic
V1 (Vds 0) vsource dc=Vds type=dc
V0 (Vgs 0) vsource dc=Vgs type=dc
M0 (Vds Vgs 0 0) nfet
simulatorOptions options temp=27 redefinedparams=warning
dcOp dc
dc dc param=Vds start=0 stop=0.8
save Vds M0:d
// saveOptions options save=all pwr=all currents=all saveahdlvars=all
